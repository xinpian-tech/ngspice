* ICsprout 55LLULP MOM equations at -40 C

.option temp=-40

va na 0 dc -0.8 ac 1
vb nb 0 dc 0.4 ac 0
vp np 0 dc 0 ac 0
a3 na nb na np nb np mom3
.model mom3 icsmom (lf=0.4u nf=5 bm=1 tm=4 mr=1 mismod=1 shielding=0 dmom=0.1 sigma_mis=-1.25)

.control
ac lin 1 1meg 1meg
let err_a = abs((imag(i(va)) + 6.7581587925884930e-9) / 6.7581587925884930e-9)
let err_b = abs((imag(i(vb)) - 6.0923919014945426e-9) / 6.0923919014945426e-9)
let err_p = abs((imag(i(vp)) - 6.6576689109395120e-10) / 6.6576689109395120e-10)
if (err_a > 1e-10) or (err_b > 1e-10) or (err_p > 1e-10)
  echo "ERROR: low-temperature MOM process/mismatch equations"
  quit 1
end

echo "INFO: success"
quit 0
.endc

.end
