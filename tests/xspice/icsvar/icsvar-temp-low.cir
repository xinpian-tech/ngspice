* ICsprout 55LLULP varactor equations at -40 C

.option temp=-40

v12 n12 0 dc -0.8 ac 1
a12 n12 0 var12
.model var12 icsvar (variant=12 l=0.25u w=0.6u nf=2 mr=1 mismod=1 dcgg=-0.03 dtox=4.8e-11 sigma_mis=-1.25)

v33 n33 0 dc -1.5 ac 1
a33 n33 0 var33
.model var33 icsvar (variant=33 l=0.4u w=0.8u nf=3 mr=1 mismod=1 dcgg=-0.03 dtox=0 sigma_mis=-1.25)

.control
op
let err_i12 = abs((i(v12) - 2.2949227976950254e-12) / 2.2949227976950254e-12)
if err_i12 > 1e-10
  echo "ERROR: low-temperature gate-current equation"
  quit 1
end

ac lin 1 1meg 1meg
let err_c12 = abs((imag(i(v12)) + 1.4017350005038426e-8) / 1.4017350005038426e-8)
let err_c33 = abs((imag(i(v33)) + 2.1499068900649500e-8) / 2.1499068900649500e-8)
if err_c12 > 1e-10
  echo "ERROR: low-temperature 1.2 V capacitance equation"
  quit 1
end
if err_c33 > 1e-10
  echo "ERROR: low-temperature 3.3 V capacitance equation"
  quit 1
end

echo "INFO: success"
quit 0
.endc

.end
