* arbitrary current noise power spectral density

vinput in 0 dc 1 ac 1
rbias in 0 1k noisy=0
rload out 0 1k noisy=0
bnoise out 0 noise={1e-12*pwr(abs(i(vinput)),2)/hertz}

.control
set noinit
noise v(out) vinput dec 1 1k 10k
setplot noise1
let expected = 3.162277660168379e-8
let error = abs(onoise_spectrum[0] / expected - 1)

if error > 1e-9
  echo "ERROR: arbitrary current noise PSD test failed"
  quit 1
else
  echo "INFO: success"
  quit 0
end
.endc

.end
